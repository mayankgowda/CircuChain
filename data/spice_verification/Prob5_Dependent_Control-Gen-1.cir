* Prob 5: Dependent
* EXPECTED TRUTH:
* i1 (i(v_sense_i1)) = 0.434584
* i2 (i(v_sense_i2)) = 0.327576
* vx (v(2))  = 5.3504

V1 1 0 DC 11
R1 1 1_sense 13
V_sense_i1 1_sense 2 DC 0
R_share 2 0 50

E_dep 3 2 2 0 2

R2 3 3_sense 49
V_sense_i2 3_sense 0 DC 0

.op
.print op v(2) i(v_sense_i1) i(v_sense_i2)
.end

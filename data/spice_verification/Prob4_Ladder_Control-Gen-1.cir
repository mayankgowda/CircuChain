* Prob 4: Ladder
* EXPECTED TRUTH:
* i1 (i(v_sense_i1)) = 0.004434
* i2 (i(v_sense_i2)) = 0.002458
* i3 (i(v_sense_i3)) = 0.000375
* v1 (v(2))  = 7.1487
* v2 (v(3))  = 2.6648
* v3 (v(4))  = 1.0678

V1 1 0 DC 28
R1 1 1_sense 4703
V_sense_i1 1_sense 2 DC 0
R2 2 0 3619

R3 2 2_sense 1824
V_sense_i2 2_sense 3 DC 0
R4 3 0 1279

R5 3 3_sense 4261
V_sense_i3 3_sense 4 DC 0
R6 4 0 2849

.op
.print op v(2) v(3) v(4) i(v_sense_i1) i(v_sense_i2) i(v_sense_i3)
.end

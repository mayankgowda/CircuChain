* Prob 3: Bridge
* EXPECTED TRUTH:
* i1 (i(v_sense_i1)) = 0.138474
* va (v(2))     = 10.6018
* vb (v(3))     = 24.7882

V_src 1_src 0 DC 27
V_sense_i1 1_src 1 DC 0

R_LT 1 2 194
R_LB 2 0 87

R_RT 1 3 41
R_RB 3 0 1492

R_Br 2 3 380

.op
.print op v(2) v(3) i(v_sense_i1)
.end

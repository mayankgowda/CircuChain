* Prob 3: Bridge
* EXPECTED TRUTH:
* i1 (i(v_sense_i1)) = 1.885108
* va (v(2))     = 189.2972
* vb (v(3))     = 217.9094

V_src 1_src 0 DC 297
V_sense_i1 1_src 1 DC 0

R_LT 1 2 183
R_LB 2 0 201

R_RT 1 3 61
R_RB 3 0 231

R_Br 2 3 81

.op
.print op v(2) v(3) i(v_sense_i1)
.end

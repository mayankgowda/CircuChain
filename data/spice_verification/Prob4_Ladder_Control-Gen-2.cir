* Prob 4: Ladder
* EXPECTED TRUTH:
* i1 (i(v_sense_i1)) = 0.006822
* i2 (i(v_sense_i2)) = 0.003035
* i3 (i(v_sense_i3)) = 0.000714
* v1 (v(2))  = 12.0474
* v2 (v(3))  = 6.3236
* v3 (v(4))  = 3.3875

V1 1 0 DC 43
R1 1 1_sense 4537
V_sense_i1 1_sense 2 DC 0
R2 2 0 3181

R3 2 2_sense 1886
V_sense_i2 2_sense 3 DC 0
R4 3 0 2725

R5 3 3_sense 4110
V_sense_i3 3_sense 4 DC 0
R6 4 0 4742

.op
.print op v(2) v(3) v(4) i(v_sense_i1) i(v_sense_i2) i(v_sense_i3)
.end

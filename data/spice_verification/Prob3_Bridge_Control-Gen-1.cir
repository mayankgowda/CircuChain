* Prob 3: Bridge
* EXPECTED TRUTH:
* i1 (i(v_sense_i1)) = 0.597125
* va (v(2))     = 73.4381
* vb (v(3))     = 81.8593

V_src 1_src 0 DC 100
V_sense_i1 1_src 1 DC 0

R_LT 1 2 131
R_LB 2 0 275

R_RT 1 3 46
R_RB 3 0 248

R_Br 2 3 131

.op
.print op v(2) v(3) i(v_sense_i1)
.end

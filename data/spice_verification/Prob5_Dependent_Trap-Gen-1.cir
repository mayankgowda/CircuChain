* Prob 5: Dependent
* EXPECTED TRUTH:
* i1 (i(v_sense_i1)) = 1.353641
* i2 (i(v_sense_i2)) = 1.311756
* vx (v(2))  = 2.2199

V1 1 0 DC 32
R1 1 1_sense 22
V_sense_i1 1_sense 2 DC 0
R_share 2 0 53

E_dep 3 2 2 0 12

R2 3 3_sense 22
V_sense_i2 3_sense 0 DC 0

.op
.print op v(2) i(v_sense_i1) i(v_sense_i2)
.end

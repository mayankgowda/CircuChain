* Prob 3: Bridge
* EXPECTED TRUTH:
* i1 (i(v_sense_i1)) = 0.241902
* va (v(2))     = 16.5789
* vb (v(3))     = 38.0117

V_src 1_src 0 DC 42
V_sense_i1 1_src 1 DC 0

R_LT 1 2 173
R_LB 2 0 82

R_RT 1 3 42
R_RB 3 0 957

R_Br 2 3 388

.op
.print op v(2) v(3) i(v_sense_i1)
.end

* Prob 5: Dependent
* EXPECTED TRUTH:
* i1 (i(v_sense_i1)) = 0.778190
* i2 (i(v_sense_i2)) = 0.503970
* vx (v(2))  = 4.6617

V1 1 0 DC 14
R1 1 1_sense 12
V_sense_i1 1_sense 2 DC 0
R_share 2 0 17

E_dep 3 2 2 0 3

R2 3 3_sense 37
V_sense_i2 3_sense 0 DC 0

.op
.print op v(2) i(v_sense_i1) i(v_sense_i2)
.end

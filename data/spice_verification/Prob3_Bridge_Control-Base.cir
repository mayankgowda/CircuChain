* Prob 3: Bridge
* EXPECTED TRUTH:
* i1 (i(v_sense_i1)) = 1.360920
* va (v(2))     = 176.5517
* vb (v(3))     = 193.1034

V_src 1_src 0 DC 240
V_sense_i1 1_src 1 DC 0

R_LT 1 2 150
R_LB 2 0 300

R_RT 1 3 50
R_RB 3 0 250

R_Br 2 3 100

.op
.print op v(2) v(3) i(v_sense_i1)
.end

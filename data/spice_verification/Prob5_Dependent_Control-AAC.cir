* Prob 5: Dependent
* EXPECTED TRUTH:
* i1 (i(v_sense_i1)) = 0.021429
* i2 (i(v_sense_i2)) = 0.017143
* vx (v(2))  = 0.8571

V1 1 0 DC 3
R1 1 1_sense 100
V_sense_i1 1_sense 2 DC 0
R_share 2 0 200

E_dep 3 2 2 0 5

R2 3 3_sense 300
V_sense_i2 3_sense 0 DC 0

.op
.print op v(2) i(v_sense_i1) i(v_sense_i2)
.end

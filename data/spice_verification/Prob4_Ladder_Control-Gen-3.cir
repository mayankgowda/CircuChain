* Prob 4: Ladder
* EXPECTED TRUTH:
* i1 (i(v_sense_i1)) = 0.016012
* i2 (i(v_sense_i2)) = 0.005531
* i3 (i(v_sense_i3)) = 0.001395
* v1 (v(2))  = 23.3289
* v2 (v(3))  = 7.1935
* v3 (v(4))  = 2.3630

V1 1 0 DC 55
R1 1 1_sense 1978
V_sense_i1 1_sense 2 DC 0
R2 2 0 2226

R3 2 2_sense 2917
V_sense_i2 2_sense 3 DC 0
R4 3 0 1739

R5 3 3_sense 3463
V_sense_i3 3_sense 4 DC 0
R6 4 0 1694

.op
.print op v(2) v(3) v(4) i(v_sense_i1) i(v_sense_i2) i(v_sense_i3)
.end

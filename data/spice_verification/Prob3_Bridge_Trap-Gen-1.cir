* Prob 3: Bridge
* EXPECTED TRUTH:
* i1 (i(v_sense_i1)) = 0.332335
* va (v(2))     = 17.0611
* vb (v(3))     = 41.2214

V_src 1_src 0 DC 50
V_sense_i1 1_src 1 DC 0

R_LT 1 2 153
R_LB 2 0 59

R_RT 1 3 75
R_RB 3 0 955

R_Br 2 3 327

.op
.print op v(2) v(3) i(v_sense_i1)
.end

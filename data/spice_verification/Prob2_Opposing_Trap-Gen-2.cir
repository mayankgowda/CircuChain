* Prob 2: Opposing
* EXPECTED TRUTH:
* i1 (i(v_sense_i1)) = -0.875000
* i2 (i(v_sense_i2)) = -15.937500
* v1 (v(2))  = 30.1250

V1 1 0 DC 24
R1 1 1_sense 7
V_sense_i1 1_sense 2 DC 0

R_share 2 0 2

R2 2 2_sense 2
V_sense_i2 2_sense 3 DC 0

V2 3 0 DC 62

.op
.print op v(2) i(v_sense_i1) i(v_sense_i2)
.end

* Prob 3: Bridge
* EXPECTED TRUTH:
* i1 (i(v_sense_i1)) = 1.604999
* va (v(2))     = 211.0119
* vb (v(3))     = 230.8009

V_src 1_src 0 DC 296
V_sense_i1 1_src 1 DC 0

R_LT 1 2 170
R_LB 2 0 328

R_RT 1 3 59
R_RB 3 0 240

R_Br 2 3 138

.op
.print op v(2) v(3) i(v_sense_i1)
.end
